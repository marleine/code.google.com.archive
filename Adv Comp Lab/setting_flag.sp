* FILE: setting_flag.sp

********************** begin header *****************************

* Example header file for SPICE

.OPTIONS post ACCT OPTS lvltim=2
.OPTIONS post_version=9007

.option gmindc=   10.0p

.options ADM_V_SUPPLY=3.3
*.options ADM_ACCURACY=10
*.options ADM_MODE=exp
.options ADM_MODE=acs
*.options ADM_MAXSTEP=10p
.options ignore_meas=0
*.param temper = 105

**################################################
* Corners are TT, SS, FF, SF, FS
.lib '<spice_model_file>' TT
**################################################

.param  arean(w,sdd) = '(w*sdd*1p)'
.param  areap(w,sdd) = '(w*sdd*1p)'
* Setup either one or the other of the following
* For ACM=2 fet models
.param  perin(w,sdd) = '(2u*(w+sdd))'
.param  perip(w,sdd) = '(2u*(w+sdd))'
* For ACM=3 fet models
*.param  perin(w,sdd) = '(1u*(w+2*sdd))'
*.param  perip(w,sdd) = '(1u*(w+2*sdd))'

.param ln_min   =  0.35u
.param lp_min   =  0.35u

* used in source/drain area/perimeter calculation
.param sdd        =  0.95

.PARAM vddp=3.0		$ VDD voltage

VDD vdd 0 DC vddp

.TEMP 105
.TRAN 10p 16n
*********************** end header ******************************

* SPICE netlist for "setting_flag" (generated by MMI_SUE4.4.0)

.SUBCKT nor32 in0 in1 in10 in11 in12 in13 in14 in15 in16 in17 in18 in19 in2
+ in20 in21 in22 in23 in24 in25 in26 in27 in28 in29 in3 in30 in31 in4 in5
+ in6 in7 in8 in9 out WP=64 WN=1
M_1 out in31 gnd gnd n W='WN*1u' L=ln_min ad='arean(WN,sdd)'
+ as='arean(WN,sdd)' pd='perin(WN,sdd)' ps='perin(WN,sdd)'
M_2 out in31 net_21 vdd p W='WP*1u' L=lp_min ad='areap(WP,sdd)'
+ as='areap(WP,sdd)' pd='perip(WP,sdd)' ps='perip(WP,sdd)'
M_3 out in30 gnd gnd n W='WN*1u' L=ln_min ad='arean(WN,sdd)'
+ as='arean(WN,sdd)' pd='perin(WN,sdd)' ps='perin(WN,sdd)'
M_4 net_21 in30 net_19 vdd p W='WP*1u' L=lp_min ad='areap(WP,sdd)'
+ as='areap(WP,sdd)' pd='perip(WP,sdd)' ps='perip(WP,sdd)'
M_5 out in29 gnd gnd n W='WN*1u' L=ln_min ad='arean(WN,sdd)'
+ as='arean(WN,sdd)' pd='perin(WN,sdd)' ps='perin(WN,sdd)'
M_6 net_19 in29 net_29 vdd p W='WP*1u' L=lp_min ad='areap(WP,sdd)'
+ as='areap(WP,sdd)' pd='perip(WP,sdd)' ps='perip(WP,sdd)'
M_7 out in28 gnd gnd n W='WN*1u' L=ln_min ad='arean(WN,sdd)'
+ as='arean(WN,sdd)' pd='perin(WN,sdd)' ps='perin(WN,sdd)'
M_8 net_29 in28 net_8 vdd p W='WP*1u' L=lp_min ad='areap(WP,sdd)'
+ as='areap(WP,sdd)' pd='perip(WP,sdd)' ps='perip(WP,sdd)'
M_9 out in27 gnd gnd n W='WN*1u' L=ln_min ad='arean(WN,sdd)'
+ as='arean(WN,sdd)' pd='perin(WN,sdd)' ps='perin(WN,sdd)'
M_10 net_8 in27 net_17 vdd p W='WP*1u' L=lp_min ad='areap(WP,sdd)'
+ as='areap(WP,sdd)' pd='perip(WP,sdd)' ps='perip(WP,sdd)'
M_11 out in26 gnd gnd n W='WN*1u' L=ln_min ad='arean(WN,sdd)'
+ as='arean(WN,sdd)' pd='perin(WN,sdd)' ps='perin(WN,sdd)'
M_12 net_17 in26 net_27 vdd p W='WP*1u' L=lp_min ad='areap(WP,sdd)'
+ as='areap(WP,sdd)' pd='perip(WP,sdd)' ps='perip(WP,sdd)'
M_13 out in25 gnd gnd n W='WN*1u' L=ln_min ad='arean(WN,sdd)'
+ as='arean(WN,sdd)' pd='perin(WN,sdd)' ps='perin(WN,sdd)'
M_14 net_27 in25 net_6 vdd p W='WP*1u' L=lp_min ad='areap(WP,sdd)'
+ as='areap(WP,sdd)' pd='perip(WP,sdd)' ps='perip(WP,sdd)'
M_15 out in24 gnd gnd n W='WN*1u' L=ln_min ad='arean(WN,sdd)'
+ as='arean(WN,sdd)' pd='perin(WN,sdd)' ps='perin(WN,sdd)'
M_16 net_6 in24 net_15 vdd p W='WP*1u' L=lp_min ad='areap(WP,sdd)'
+ as='areap(WP,sdd)' pd='perip(WP,sdd)' ps='perip(WP,sdd)'
M_17 out in23 gnd gnd n W='WN*1u' L=ln_min ad='arean(WN,sdd)'
+ as='arean(WN,sdd)' pd='perin(WN,sdd)' ps='perin(WN,sdd)'
M_18 net_15 in23 net_25 vdd p W='WP*1u' L=lp_min ad='areap(WP,sdd)'
+ as='areap(WP,sdd)' pd='perip(WP,sdd)' ps='perip(WP,sdd)'
M_19 out in22 gnd gnd n W='WN*1u' L=ln_min ad='arean(WN,sdd)'
+ as='arean(WN,sdd)' pd='perin(WN,sdd)' ps='perin(WN,sdd)'
M_20 net_25 in22 net_2 vdd p W='WP*1u' L=lp_min ad='areap(WP,sdd)'
+ as='areap(WP,sdd)' pd='perip(WP,sdd)' ps='perip(WP,sdd)'
M_21 out in21 gnd gnd n W='WN*1u' L=ln_min ad='arean(WN,sdd)'
+ as='arean(WN,sdd)' pd='perin(WN,sdd)' ps='perin(WN,sdd)'
M_22 net_2 in21 net_14 vdd p W='WP*1u' L=lp_min ad='areap(WP,sdd)'
+ as='areap(WP,sdd)' pd='perip(WP,sdd)' ps='perip(WP,sdd)'
M_23 out in20 gnd gnd n W='WN*1u' L=ln_min ad='arean(WN,sdd)'
+ as='arean(WN,sdd)' pd='perin(WN,sdd)' ps='perin(WN,sdd)'
M_24 net_14 in20 net_24 vdd p W='WP*1u' L=lp_min ad='areap(WP,sdd)'
+ as='areap(WP,sdd)' pd='perip(WP,sdd)' ps='perip(WP,sdd)'
M_25 out in19 gnd gnd n W='WN*1u' L=ln_min ad='arean(WN,sdd)'
+ as='arean(WN,sdd)' pd='perin(WN,sdd)' ps='perin(WN,sdd)'
M_26 net_24 in19 net_5 vdd p W='WP*1u' L=lp_min ad='areap(WP,sdd)'
+ as='areap(WP,sdd)' pd='perip(WP,sdd)' ps='perip(WP,sdd)'
M_27 out in18 gnd gnd n W='WN*1u' L=ln_min ad='arean(WN,sdd)'
+ as='arean(WN,sdd)' pd='perin(WN,sdd)' ps='perin(WN,sdd)'
M_28 net_5 in18 net_13 vdd p W='WP*1u' L=lp_min ad='areap(WP,sdd)'
+ as='areap(WP,sdd)' pd='perip(WP,sdd)' ps='perip(WP,sdd)'
M_29 out in17 gnd gnd n W='WN*1u' L=ln_min ad='arean(WN,sdd)'
+ as='arean(WN,sdd)' pd='perin(WN,sdd)' ps='perin(WN,sdd)'
M_30 net_13 in17 net_23 vdd p W='WP*1u' L=lp_min ad='areap(WP,sdd)'
+ as='areap(WP,sdd)' pd='perip(WP,sdd)' ps='perip(WP,sdd)'
M_31 out in16 gnd gnd n W='WN*1u' L=ln_min ad='arean(WN,sdd)'
+ as='arean(WN,sdd)' pd='perin(WN,sdd)' ps='perin(WN,sdd)'
M_32 net_23 in16 net_1 vdd p W='WP*1u' L=lp_min ad='areap(WP,sdd)'
+ as='areap(WP,sdd)' pd='perip(WP,sdd)' ps='perip(WP,sdd)'
M_33 out in15 gnd gnd n W='WN*1u' L=ln_min ad='arean(WN,sdd)'
+ as='arean(WN,sdd)' pd='perin(WN,sdd)' ps='perin(WN,sdd)'
M_34 net_1 in15 net_12 vdd p W='WP*1u' L=lp_min ad='areap(WP,sdd)'
+ as='areap(WP,sdd)' pd='perip(WP,sdd)' ps='perip(WP,sdd)'
M_35 out in14 gnd gnd n W='WN*1u' L=ln_min ad='arean(WN,sdd)'
+ as='arean(WN,sdd)' pd='perin(WN,sdd)' ps='perin(WN,sdd)'
M_36 net_12 in14 net_22 vdd p W='WP*1u' L=lp_min ad='areap(WP,sdd)'
+ as='areap(WP,sdd)' pd='perip(WP,sdd)' ps='perip(WP,sdd)'
M_37 out in13 gnd gnd n W='WN*1u' L=ln_min ad='arean(WN,sdd)'
+ as='arean(WN,sdd)' pd='perin(WN,sdd)' ps='perin(WN,sdd)'
M_38 net_22 in13 net_31 vdd p W='WP*1u' L=lp_min ad='areap(WP,sdd)'
+ as='areap(WP,sdd)' pd='perip(WP,sdd)' ps='perip(WP,sdd)'
M_39 out in12 gnd gnd n W='WN*1u' L=ln_min ad='arean(WN,sdd)'
+ as='arean(WN,sdd)' pd='perin(WN,sdd)' ps='perin(WN,sdd)'
M_40 net_31 in12 net_10 vdd p W='WP*1u' L=lp_min ad='areap(WP,sdd)'
+ as='areap(WP,sdd)' pd='perip(WP,sdd)' ps='perip(WP,sdd)'
M_41 out in11 gnd gnd n W='WN*1u' L=ln_min ad='arean(WN,sdd)'
+ as='arean(WN,sdd)' pd='perin(WN,sdd)' ps='perin(WN,sdd)'
M_42 net_10 in11 net_11 vdd p W='WP*1u' L=lp_min ad='areap(WP,sdd)'
+ as='areap(WP,sdd)' pd='perip(WP,sdd)' ps='perip(WP,sdd)'
M_43 out in10 gnd gnd n W='WN*1u' L=ln_min ad='arean(WN,sdd)'
+ as='arean(WN,sdd)' pd='perin(WN,sdd)' ps='perin(WN,sdd)'
M_44 net_11 in10 net_20 vdd p W='WP*1u' L=lp_min ad='areap(WP,sdd)'
+ as='areap(WP,sdd)' pd='perip(WP,sdd)' ps='perip(WP,sdd)'
M_45 out in9 gnd gnd n W='WN*1u' L=ln_min ad='arean(WN,sdd)'
+ as='arean(WN,sdd)' pd='perin(WN,sdd)' ps='perin(WN,sdd)'
M_46 net_20 in9 net_30 vdd p W='WP*1u' L=lp_min ad='areap(WP,sdd)'
+ as='areap(WP,sdd)' pd='perip(WP,sdd)' ps='perip(WP,sdd)'
M_47 out in8 gnd gnd n W='WN*1u' L=ln_min ad='arean(WN,sdd)'
+ as='arean(WN,sdd)' pd='perin(WN,sdd)' ps='perin(WN,sdd)'
M_48 net_30 in8 net_9 vdd p W='WP*1u' L=lp_min ad='areap(WP,sdd)'
+ as='areap(WP,sdd)' pd='perip(WP,sdd)' ps='perip(WP,sdd)'
M_49 out in7 gnd gnd n W='WN*1u' L=ln_min ad='arean(WN,sdd)'
+ as='arean(WN,sdd)' pd='perin(WN,sdd)' ps='perin(WN,sdd)'
M_50 net_9 in7 net_18 vdd p W='WP*1u' L=lp_min ad='areap(WP,sdd)'
+ as='areap(WP,sdd)' pd='perip(WP,sdd)' ps='perip(WP,sdd)'
M_51 out in6 gnd gnd n W='WN*1u' L=ln_min ad='arean(WN,sdd)'
+ as='arean(WN,sdd)' pd='perin(WN,sdd)' ps='perin(WN,sdd)'
M_52 net_18 in6 net_28 vdd p W='WP*1u' L=lp_min ad='areap(WP,sdd)'
+ as='areap(WP,sdd)' pd='perip(WP,sdd)' ps='perip(WP,sdd)'
M_53 out in5 gnd gnd n W='WN*1u' L=ln_min ad='arean(WN,sdd)'
+ as='arean(WN,sdd)' pd='perin(WN,sdd)' ps='perin(WN,sdd)'
M_54 net_28 in5 net_7 vdd p W='WP*1u' L=lp_min ad='areap(WP,sdd)'
+ as='areap(WP,sdd)' pd='perip(WP,sdd)' ps='perip(WP,sdd)'
M_55 out in4 gnd gnd n W='WN*1u' L=ln_min ad='arean(WN,sdd)'
+ as='arean(WN,sdd)' pd='perin(WN,sdd)' ps='perin(WN,sdd)'
M_56 net_7 in4 net_16 vdd p W='WP*1u' L=lp_min ad='areap(WP,sdd)'
+ as='areap(WP,sdd)' pd='perip(WP,sdd)' ps='perip(WP,sdd)'
M_57 out in3 gnd gnd n W='WN*1u' L=ln_min ad='arean(WN,sdd)'
+ as='arean(WN,sdd)' pd='perin(WN,sdd)' ps='perin(WN,sdd)'
M_58 net_16 in3 net_26 vdd p W='WP*1u' L=lp_min ad='areap(WP,sdd)'
+ as='areap(WP,sdd)' pd='perip(WP,sdd)' ps='perip(WP,sdd)'
M_59 out in2 gnd gnd n W='WN*1u' L=ln_min ad='arean(WN,sdd)'
+ as='arean(WN,sdd)' pd='perin(WN,sdd)' ps='perin(WN,sdd)'
M_60 net_26 in2 net_3 vdd p W='WP*1u' L=lp_min ad='areap(WP,sdd)'
+ as='areap(WP,sdd)' pd='perip(WP,sdd)' ps='perip(WP,sdd)'
M_61 out in1 gnd gnd n W='WN*1u' L=ln_min ad='arean(WN,sdd)'
+ as='arean(WN,sdd)' pd='perin(WN,sdd)' ps='perin(WN,sdd)'
M_62 net_3 in1 net_4 vdd p W='WP*1u' L=lp_min ad='areap(WP,sdd)'
+ as='areap(WP,sdd)' pd='perip(WP,sdd)' ps='perip(WP,sdd)'
M_63 out in0 gnd gnd n W='WN*1u' L=ln_min ad='arean(WN,sdd)'
+ as='arean(WN,sdd)' pd='perin(WN,sdd)' ps='perin(WN,sdd)'
M_64 net_4 in0 vdd vdd p W='WP*1u' L=lp_min ad='areap(WP,sdd)'
+ as='areap(WP,sdd)' pd='perip(WP,sdd)' ps='perip(WP,sdd)'
.ENDS	$ nor32

.SUBCKT neg A[0] A[1] A[2] A[3] A[4] A[5] A[6] A[7] A[8] A[9] A[10] A[11]
+ A[12] A[13] A[14] A[15] A[16] A[17] A[18] A[19] A[20] A[21] A[22] A[23]
+ A[24] A[25] A[26] A[27] A[28] A[29] A[30] A[31] out
Xnor32 A[0] A[1] A[10] A[11] A[12] A[13] A[14] A[15] A[16] A[17] A[18]
+ A[19] A[2] A[20] A[21] A[22] A[23] A[24] A[25] A[26] A[27] A[28] A[29]
+ A[3] A[30] A[31] A[4] A[5] A[6] A[7] A[8] A[9] out nor32 WP=4
.ENDS	$ neg

.SUBCKT inverter in out WP=2 LP=lp_min WN=1 LN=ln_min
M_1 out in gnd gnd n W='WN*1u' L=LN ad='arean(WN,sdd)' as='arean(WN,sdd)'
+ pd='perin(WN,sdd)' ps='perin(WN,sdd)'
M_2 out in vdd vdd p W='WP*1u' L=LP ad='areap(WP,sdd)' as='areap(WP,sdd)'
+ pd='perip(WP,sdd)' ps='perip(WP,sdd)'
.ENDS	$ inverter

.SUBCKT flags data out write
Xinverter data net_2 inverter
Xinverter_1 out net_1 inverter
M_1 net_1 write net_2 gnd n W='1*1u' L=ln_min ad='arean(1,sdd)'
+ as='arean(1,sdd)' pd='perin(1,sdd)' ps='perin(1,sdd)' M=4
Xinverter_2 net_1 out inverter M=4
.ENDS	$ flags

.SUBCKT nor2 in0 in1 out WP=4 WN=1
M_1 out in1 gnd gnd n W='WN*1u' L=ln_min ad='arean(WN,sdd)'
+ as='arean(WN,sdd)' pd='perin(WN,sdd)' ps='perin(WN,sdd)'
M_2 out in1 net_1 vdd p W='WP*1u' L=lp_min ad='areap(WP,sdd)'
+ as='areap(WP,sdd)' pd='perip(WP,sdd)' ps='perip(WP,sdd)'
M_3 out in0 gnd gnd n W='WN*1u' L=ln_min ad='arean(WN,sdd)'
+ as='arean(WN,sdd)' pd='perin(WN,sdd)' ps='perin(WN,sdd)'
M_4 net_1 in0 vdd vdd p W='WP*1u' L=lp_min ad='areap(WP,sdd)'
+ as='areap(WP,sdd)' pd='perip(WP,sdd)' ps='perip(WP,sdd)'
.ENDS	$ nor2

.SUBCKT nand2 in0 in1 out WP=2 WN=2
M_1 out in0 vdd vdd p W='WP*1u' L=lp_min ad='areap(WP,sdd)'
+ as='areap(WP,sdd)' pd='perip(WP,sdd)' ps='perip(WP,sdd)'
M_2 out in0 net_1 gnd n W='WN*1u' L=ln_min ad='arean(WN,sdd)'
+ as='arean(WN,sdd)' pd='perin(WN,sdd)' ps='perin(WN,sdd)'
M_3 out in1 vdd vdd p W='WP*1u' L=lp_min ad='areap(WP,sdd)'
+ as='areap(WP,sdd)' pd='perip(WP,sdd)' ps='perip(WP,sdd)'
M_4 net_1 in1 gnd gnd n W='WN*1u' L=ln_min ad='arean(WN,sdd)'
+ as='arean(WN,sdd)' pd='perin(WN,sdd)' ps='perin(WN,sdd)'
.ENDS	$ nand2

* start main CELL setting_flag
* .SUBCKT setting_flag ALU_Result[0] ALU_Result[1] ALU_Result[2]
*+ ALU_Result[3] ALU_Result[4] ALU_Result[5] ALU_Result[6] ALU_Result[7]
*+ ALU_Result[8] ALU_Result[9] ALU_Result[10] ALU_Result[11] ALU_Result[12]
*+ ALU_Result[13] ALU_Result[14] ALU_Result[15] ALU_Result[16]
*+ ALU_Result[17] ALU_Result[18] ALU_Result[19] ALU_Result[20]
*+ ALU_Result[21] ALU_Result[22] ALU_Result[23] ALU_Result[24]
*+ ALU_Result[25] ALU_Result[26] ALU_Result[27] ALU_Result[28]
*+ ALU_Result[29] ALU_Result[30] ALU_Result[31] IR[11] IR[30] IR[31] N P Z
Xneg ALU_Result[0] ALU_Result[1] ALU_Result[2] ALU_Result[3] ALU_Result[4]
+ ALU_Result[5] ALU_Result[6] ALU_Result[7] ALU_Result[8] ALU_Result[9]
+ ALU_Result[10] ALU_Result[11] ALU_Result[12] ALU_Result[13]
+ ALU_Result[14] ALU_Result[15] ALU_Result[16] ALU_Result[17]
+ ALU_Result[18] ALU_Result[19] ALU_Result[20] ALU_Result[21]
+ ALU_Result[22] ALU_Result[23] ALU_Result[24] ALU_Result[25]
+ ALU_Result[26] ALU_Result[27] ALU_Result[28] ALU_Result[29]
+ ALU_Result[30] ALU_Result[31] net_3 neg
Xflags net_3 Z net_1 flags
Xflags_1 ALU_Result[31] N net_1 flags
Xflags_2 net_5 P net_1 flags
Xnor2 net_3 ALU_Result[31] net_5 nor2
Xnor2_1 IR[30] IR[31] net_2 nor2
Xnand2 net_2 IR[11] net_4 nand2
Xinverter net_4 net_1 inverter
* .ENDS	$ setting_flag

.GLOBAL gnd vdd

.END
